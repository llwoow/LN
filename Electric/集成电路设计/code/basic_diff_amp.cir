* 基本差分放大器LTspice仿真
VCC 10 0 5V
VEE 20 0 -5V
V1 1 0 SIN(0 1mV 1kHz)
V2 2 0 SIN(0 1mV 1kHz 180)
Q1 3 1 20 Q2N2222
Q2 4 2 20 Q2N2222
I1 20 5 1mA
R1 10 3 10k
R2 10 4 10k
.op
.ac dec 100 1 1meg
.tran 0 1ms 0 1us
.end
